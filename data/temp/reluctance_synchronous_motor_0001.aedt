# Ansys Electronics Desktop project, version 2025.2

design RMxprtSolution_U1O (RMxprt, Generic Rotating Machines, model units mm)
machine:
  Machine: RotorType=3 StatorType=0 SourceType=0 Structure=0 ImportRotor=0 ImportStator=0 StatorCenter=0 RotorCenter=0 ImportType MasterSlaveOnXais Fraction=0 AirGapLength=0mm DoubleSided=0
  Stator: NumberOfPoles=2 NumberOfSlots=18 SlotType=1 CircuitType=0
  Rotor: NumberOfSlots=0
  Shaft: MagneticShaft FrictionLoss=0W WindLoss=0W ReferenceSpeed=0rpm
  Stator Core: OuterDiameter=0mm InnerDiameter=0mm Length=0mm StackingFactor=0.95 LaminationSectors=0 PressBoardThickness=0mm SkewWidth=0deg
  Stator Winding: WindingType=Whole-Coiled WindingLayers=2 ParallelBranches=0 ConductorsPerSlot=0 CoilPitch=0 EndAdjustment=0mm BaseInnerRadius=0mm TipInnerDiameter=0mm EndClearance=0mm CoilWrap=0mm SlotLiner=0mm WedgeThickness=0mm LayerInsulation=0mm BottomInsulation=0mm LimitedFillFactor=0.75 WdgNumberofPriodicMultipler=1 NumberOfStrands=0 WireWrap=0mm InterturnInsulation=0mm WireDiameter=0mm WireWidth=0mm WireThickness=0mm Gauge=AUTO CorrectionFactor=1 TopSpareSpace=0 BottomSpareSpace=0
  Rotor Core: OuterDiameter=0mm InnerDiameter=0mm Length=0mm StackingFactor=0.95 PressBoardThickness=0mm SkewWidth=0deg
  Core Slot: Hs0=0mm Hs1=0mm Hs2=0mm Bs0=0mm Bs1=0mm Bs2=0mm Rs=0mm AutoDesign ToothWidth=0mm
  Core Damper: DamperSlotsPerPole=0 SlotType=1 EndLength=0mm EndRingWidth=0mm EndRingHeight=0mm EndRingType=0 BarFitGap=0mm
  Damper Slot: Hs0=0mm Hs1=0mm Hs2=0mm Bs0=0mm Bs1=0mm Bs2=0mm Rs=0mm Hs01=0mm
